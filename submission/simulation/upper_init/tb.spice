* ISHI core upper_init; no wire RC
.include '../models.spice'
.include '../core_sim.spice'
.temp 27
.options method=trap
VDD vdd 0 5
VCLK clk 0 PULSE(0 5 1000n 2n 2n 156.730158730159n 317.460317460317n)
XDUT hsync vdd b g r clk vsync 0 ishi_vga_core
C_r r 0 1.0p
C_g g 0 1.0p
C_b b 0 1.0p
C_hsync hsync 0 1.0p
C_vsync vsync 0 1.0p
.ic v(xdut.n20)=5 v(xdut.n23)=0
.ic v(xdut.n171)=5 v(xdut.n298)=0
.ic v(xdut.n7)=5 v(xdut.n323)=0
.ic v(xdut.n65)=0 v(xdut.n275)=5
.ic v(xdut.n209)=0 v(xdut.nI1415)=5
.ic v(xdut.n18)=0 v(xdut.nI1430)=5
.ic v(xdut.n188)=5 v(xdut.n214)=0
.ic v(xdut.n980)=0 v(xdut.n713)=5
.ic v(xdut.n986)=0 v(xdut.nI1424)=5
.ic v(xdut.n791)=0 v(xdut.nI1423)=5
.ic v(xdut.n797)=0 v(xdut.nI1413)=5
.ic v(xdut.n835)=0 v(xdut.nI1416)=5
.ic v(xdut.n518)=5 v(xdut.nI1419)=0
.ic v(xdut.n548)=0 v(xdut.n245)=5
.ic v(xdut.n520)=5 v(xdut.n519)=0
.ic v(xdut.n658)=0 v(xdut.nI1429)=5
.ic v(xdut.n1010)=5 v(xdut.n837)=0
.save v(clk) v(r) v(g) v(b) v(hsync) v(vsync) v(xdut.n20) v(xdut.n171) v(xdut.n7) v(xdut.n65) v(xdut.n209) v(xdut.n18) v(xdut.n188) v(xdut.n980) v(xdut.n986) v(xdut.n791) v(xdut.n797) v(xdut.n835) v(xdut.n518) v(xdut.n548) v(xdut.n520) v(xdut.n658) v(xdut.n1010)
.tran 1n 36120.634920634919n 0 1n
.end
