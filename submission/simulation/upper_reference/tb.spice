* ISHI core upper_init; no wire RC
.include '../models.spice'
.include '../reference_sim.spice'
.temp 27
.options method=trap
VDD vdd 0 5
VCLK clk 0 PULSE(0 5 1000n 2n 2n 156.730158730159n 317.460317460317n)
XDUT b clk g hsync r vsync vdd 0 ishi_vga_core
C_r r 0 1.0p
C_g g 0 1.0p
C_b b 0 1.0p
C_hsync hsync 0 1.0p
C_vsync vsync 0 1.0p
.tran 1n 36120.634920634919n 0 1n
.ic v(xdut.h0)=5 v(xdut._193_0)=0
.ic v(xdut.h1)=5 v(xdut._002_)=0
.ic v(xdut.h2)=5 v(xdut._004_)=0
.ic v(xdut.h3)=0 v(xdut._006_)=5
.ic v(xdut.h4)=0 v(xdut._196_)=5
.ic v(xdut.h5)=0 v(xdut._195_)=5
.ic v(xdut.h6)=5 v(xdut._008_)=0
.ic v(xdut.v0)=0 v(xdut._194_0)=5
.ic v(xdut.v1)=0 v(xdut._202_)=5
.ic v(xdut.v2)=0 v(xdut._201_)=5
.ic v(xdut.v3)=0 v(xdut._200_)=5
.ic v(xdut.v4)=0 v(xdut._199_)=5
.ic v(xdut.v5)=5 v(xdut._198_)=0
.ic v(xdut.v6)=0 v(xdut._005_)=5
.ic v(xdut.v7)=5 v(xdut._003_)=0
.ic v(xdut.v8)=0 v(xdut._197_)=5
.ic v(xdut.v9)=5 v(xdut._007_)=0
.save v(clk) v(r) v(g) v(b) v(hsync) v(vsync) v(xdut.h0) v(xdut.h1) v(xdut.h2) v(xdut.h3) v(xdut.h4) v(xdut.h5) v(xdut.h6) v(xdut.v0) v(xdut.v1) v(xdut.v2) v(xdut.v3) v(xdut.v4) v(xdut.v5) v(xdut.v6) v(xdut.v7) v(xdut.v8) v(xdut.v9)
.end
