* ISHI core frame_wrap_init; no wire RC
.include '../models.spice'
.include '../core_sim.spice'
.temp 27
.options method=trap
VDD vdd 0 5
VCLK clk 0 PULSE(0 5 1000n 2n 2n 156.730158730159n 317.460317460317n)
XDUT hsync vdd b g r clk vsync 0 ishi_vga_core
C_r r 0 1.0p
C_g g 0 1.0p
C_b b 0 1.0p
C_hsync hsync 0 1.0p
C_vsync vsync 0 1.0p
.ic v(xdut.n20)=5 v(xdut.n23)=0
.ic v(xdut.n172)=5 v(xdut.n298)=0
.ic v(xdut.n7)=5 v(xdut.n323)=0
.ic v(xdut.n65)=0 v(xdut.n265)=5
.ic v(xdut.n210)=0 v(xdut.nI1422)=5
.ic v(xdut.n18)=5 v(xdut.nI1429)=0
.ic v(xdut.n198)=5 v(xdut.n229)=0
.ic v(xdut.n984)=5 v(xdut.n690)=0
.ic v(xdut.n990)=5 v(xdut.nI1431)=0
.ic v(xdut.n767)=5 v(xdut.nI1432)=0
.ic v(xdut.n779)=5 v(xdut.nI1421)=0
.ic v(xdut.n795)=5 v(xdut.nI1426)=0
.ic v(xdut.n528)=5 v(xdut.nI1424)=0
.ic v(xdut.n577)=5 v(xdut.n244)=0
.ic v(xdut.n529)=5 v(xdut.n366)=0
.ic v(xdut.n647)=5 v(xdut.nI1417)=0
.ic v(xdut.n1000)=5 v(xdut.n818)=0
.save v(clk) v(r) v(g) v(b) v(hsync) v(vsync) v(xdut.n20) v(xdut.n172) v(xdut.n7) v(xdut.n65) v(xdut.n210) v(xdut.n18) v(xdut.n198) v(xdut.n984) v(xdut.n990) v(xdut.n767) v(xdut.n779) v(xdut.n795) v(xdut.n528) v(xdut.n577) v(xdut.n529) v(xdut.n647) v(xdut.n1000)
.tran 1n 36120.634920634919n 0 1n
.end
